// =============================================================================
// File: register_array.rdl
// Description: DSP Filter Accelerator with Register Arrays and Channels
// =============================================================================

addrmap dsp_filter_accelerator {
    name = "DSP Filter Accelerator";
    desc = "Hardware register map demonstrating 1D register arrays and multi-channel register structures";
    default regwidth = 32;
    default sw = rw;
    default hw = r;

    // --- Global Control Register ---
    reg filter_ctrl_t {
        name = "Filter Control";
        desc = "Global Accelerator Configuration and Tap Control";

        field {
            name = "ENABLE";
            desc = "Module Enable";
            sw = rw; hw = r;
            reset = 1'b0;
        } enable[0:0] = 1'b0;

        field {
            name = "MODE";
            desc = "Filter Operation Mode (0: FIR, 1: IIR, 2: Bypass)";
            sw = rw; hw = r;
            reset = 2'b00;
        } mode[2:1] = 2'b00;

        field {
            name = "NUM_TAPS";
            desc = "Number of active filter taps (1 to 8)";
            sw = rw; hw = r;
            reset = 4'h8;
        } num_taps[11:8] = 4'h8;
    } filter_ctrl @ 0x00;

    // --- Array of 8 Filter Coefficient Registers ---
    reg coeff_reg_t {
        name = "Filter Coefficient";
        desc = "32-bit Fixed Point Filter Weight (Q15 Fractional + Integer + Sign)";

        field {
            name = "FRACTIONAL";
            desc = "Q15 Fractional Weight [15:0]";
            sw = rw; hw = r;
            reset = 16'h0000;
        } fractional[15:0] = 16'h0000;

        field {
            name = "INTEGER";
            desc = "Integer Magnitude [23:16]";
            sw = rw; hw = r;
            reset = 8'h00;
        } integer[23:16] = 8'h00;

        field {
            name = "SIGN";
            desc = "Sign Bit (0: Positive, 1: Negative)";
            sw = rw; hw = r;
            reset = 1'b0;
        } sign[31:31] = 1'b0;
    };

    // Instantiate 8 contiguous coefficient registers COEFF[0] to COEFF[7]
    coeff_reg_t coeff[8] @ 0x10;

    // --- Multi-Channel Processing Pipeline (Channels 0 to 3) ---
    regfile channel_rf_t {
        name = "Channel Interface";
        desc = "Per-channel input sample injection and filtered result readback";

        reg {
            name = "Audio Input Sample";
            desc = "Write-only audio sample input port";
            field {
                name = "SAMPLE";
                desc = "24-bit Signed Audio Sample Data";
                sw = w; hw = r;
            } sample[23:0];
        } data_in @ 0x0;

        reg {
            name = "Filtered Output Sample";
            desc = "Read-only filtered output result port";
            field {
                name = "SAMPLE";
                desc = "24-bit Filtered Audio Sample Result";
                sw = r; hw = w;
                volatile = true;
            } sample[23:0];
        } data_out @ 0x4;
    };

    // Instantiate 4 channel register files CH[0] to CH[3]
    channel_rf_t ch[4] @ 0x40;
};
